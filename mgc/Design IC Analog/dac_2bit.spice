* NGSPICE file created from dac_2bit.ext - technology: sky130A

.subckt sky130_fd_pr__res_high_po_0p35_S5RWJ9 B R1 R2
X0 R1 R2 B sky130_fd_pr__res_high_po_0p35 l=17.2
.ends

.subckt sky130_fd_pr__pfet_01v8_N5VJYY B D S G
X0 S G D B sky130_fd_pr__pfet_01v8 ad=1.45 pd=10.58 as=1.45 ps=10.58 w=5 l=0.15
.ends

.subckt sky130_fd_pr__nfet_01v8_HYREKM B D S G
X0 S G D B sky130_fd_pr__nfet_01v8 ad=1.45 pd=10.58 as=1.45 ps=10.58 w=5 l=0.15
.ends

.subckt sky130_fd_pr__res_high_po_0p35_N4AVSQ B R1 R2
X0 R1 R2 B sky130_fd_pr__res_high_po_0p35 l=8.6
.ends

.subckt dac_2bit Vout b1
Xsky130_fd_pr__res_high_po_0p35_S5RWJ9_0 VSUBS sky130_fd_pr__res_high_po_0p35_S5RWJ9_1/R1
+ b1 sky130_fd_pr__res_high_po_0p35_S5RWJ9
Xsky130_fd_pr__res_high_po_0p35_S5RWJ9_1 VSUBS sky130_fd_pr__res_high_po_0p35_S5RWJ9_1/R1
+ sky130_fd_pr__nfet_01v8_HYREKM_3/S sky130_fd_pr__res_high_po_0p35_S5RWJ9
Xsky130_fd_pr__res_high_po_0p35_S5RWJ9_2 VSUBS sky130_fd_pr__nfet_01v8_HYREKM_1/S
+ sky130_fd_pr__res_high_po_0p35_S5RWJ9_2/R2 sky130_fd_pr__res_high_po_0p35_S5RWJ9
Xsky130_fd_pr__pfet_01v8_N5VJYY_0 sky130_fd_pr__pfet_01v8_N5VJYY_0/B b1 sky130_fd_pr__pfet_01v8_N5VJYY_0/S
+ b1 sky130_fd_pr__pfet_01v8_N5VJYY
Xsky130_fd_pr__pfet_01v8_N5VJYY_1 sky130_fd_pr__pfet_01v8_N5VJYY_1/B b1 sky130_fd_pr__pfet_01v8_N5VJYY_1/S
+ b1 sky130_fd_pr__pfet_01v8_N5VJYY
Xsky130_fd_pr__pfet_01v8_N5VJYY_2 sky130_fd_pr__pfet_01v8_N5VJYY_2/B b1 sky130_fd_pr__pfet_01v8_N5VJYY_2/S
+ b1 sky130_fd_pr__pfet_01v8_N5VJYY
Xsky130_fd_pr__pfet_01v8_N5VJYY_3 sky130_fd_pr__pfet_01v8_N5VJYY_3/B b1 sky130_fd_pr__pfet_01v8_N5VJYY_3/S
+ b1 sky130_fd_pr__pfet_01v8_N5VJYY
Xsky130_fd_pr__nfet_01v8_HYREKM_0 VSUBS b1 sky130_fd_pr__nfet_01v8_HYREKM_1/S b1 sky130_fd_pr__nfet_01v8_HYREKM
Xsky130_fd_pr__nfet_01v8_HYREKM_1 VSUBS b1 sky130_fd_pr__nfet_01v8_HYREKM_1/S b1 sky130_fd_pr__nfet_01v8_HYREKM
Xsky130_fd_pr__nfet_01v8_HYREKM_3 VSUBS b1 sky130_fd_pr__nfet_01v8_HYREKM_3/S b1 sky130_fd_pr__nfet_01v8_HYREKM
Xsky130_fd_pr__nfet_01v8_HYREKM_2 VSUBS b1 sky130_fd_pr__nfet_01v8_HYREKM_3/S b1 sky130_fd_pr__nfet_01v8_HYREKM
Xsky130_fd_pr__res_high_po_0p35_N4AVSQ_0 VSUBS sky130_fd_pr__res_high_po_0p35_S5RWJ9_1/R1
+ sky130_fd_pr__res_high_po_0p35_S5RWJ9_2/R2 sky130_fd_pr__res_high_po_0p35_N4AVSQ
Xsky130_fd_pr__res_high_po_0p35_N4AVSQ_1 VSUBS Vout sky130_fd_pr__res_high_po_0p35_S5RWJ9_2/R2
+ sky130_fd_pr__res_high_po_0p35_N4AVSQ
.ends
