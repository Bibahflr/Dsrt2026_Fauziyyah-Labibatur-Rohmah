* dac_2bit_ref.spice  --  SCHEMATIC reference netlist (dac2bitrapi.sch), for LVS.
* Kept under _ref name so `ext2spice` (which writes dac_2bit.spice) does not clobber it.
* Ports: Vref b0 b1 b0_bar b1_bar Vout VSS.  FET order D G S B.  res order P0 P1 B.

.subckt dac_2bit Vref b0 b1 b0_bar b1_bar Vout VSS
XM1 net1 b1     Vref VSS  sky130_fd_pr__nfet_01v8 L=0.15 W=5 nf=1 m=1
XM2 net1 b1_bar Vref Vref sky130_fd_pr__pfet_01v8 L=0.15 W=5 nf=1 m=1
XM4 net1 b1_bar VSS  VSS  sky130_fd_pr__nfet_01v8 L=0.15 W=5 nf=1 m=1
XM5 net1 b1     VSS  Vref sky130_fd_pr__pfet_01v8 L=0.15 W=5 nf=1 m=1
XM6 net2 b0     Vref VSS  sky130_fd_pr__nfet_01v8 L=0.15 W=5 nf=1 m=1
XM7 net2 b0_bar Vref Vref sky130_fd_pr__pfet_01v8 L=0.15 W=5 nf=1 m=1
XM8 net2 b0_bar VSS  VSS  sky130_fd_pr__nfet_01v8 L=0.15 W=5 nf=1 m=1
XM9 net2 b0     VSS  Vref sky130_fd_pr__pfet_01v8 L=0.15 W=5 nf=1 m=1
XR1 n0 net2 VSS sky130_fd_pr__res_high_po_0p35 L=17.2 mult=1 m=1
XR2 n1 net1 VSS sky130_fd_pr__res_high_po_0p35 L=17.2 mult=1 m=1
XR6 n0 VSS  VSS sky130_fd_pr__res_high_po_0p35 L=17.2 mult=1 m=1
XR4 n0 n1   VSS sky130_fd_pr__res_high_po_0p35 L=8.6  mult=1 m=1
XR5 n1 Vout VSS sky130_fd_pr__res_high_po_0p35 L=8.6  mult=1 m=1
.ends dac_2bit
